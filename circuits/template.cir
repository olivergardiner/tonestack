Template circuit for tonestack

* Insert you circuit in the area marked below - do not change anything else.
* The input to your circuit is node 2 relative to node 0 which is ground
* The output of your circuit must be node 3

* Four potentiometers are available for you to use in your circuit
* Each pot mus consist of two resistors: RPxLO and RPxHI
* RPxLO and RPxHI must be connected in series
* RPxHI is zero when the pot is fully CCW

* Nodes 0 to 9 are reserved

* Use insignificant resistors (e.g. 1 or 1M) to link other nodes to the pots where necessary

VIN 0 1 DC 0 AC 1
R98 1 2 56K

******** PLACE YOUR CIRCUIT HERE ********

R1 2 4 1M

******** PLACE YOUR CIRCUIT HERE ********

R99 3 0 100K

.OPTIONS NOACCT
.AC DEC 40 10 100K

.END

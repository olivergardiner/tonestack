Template circuit for tonestack

* Insert you circuit in the area marked below - do not change anything else.
* The input to your circuit is node 2 relative to node 0 which is ground
* The output of your circuit must be node 3

* Four potentiometers are available for you to use in your circuit
* Each pot mus consist of two resistors: RPxLO and RPxHI
* RPxLO and RPxHI must be connected in series
* RPxHI is zero when the pot is fully CCW

* Nodes 0 to 9 are reserved

VIN 0 1 DC 0 AC 1
R98 1 2 100

******* PLACE YOUR CIRCUIT HERE *******
.INCLUDE OPAMP1.cir

XOPAMP1 2 10 3 OPAMP1

RP1LO 10 11 5K
RP1HI 10 12 5K

R1 3  10 47K
R2 11 13 1K
R3 12 14 1K

C1 3  10 4.7N
C2 3  13 100N
C3 0  14 100N
C4 11 12 33N

******* PLACE YOUR CIRCUIT HERE *******

R99 3 0 100K

.OPTIONS NOACCT
.AC DEC 40 10 100K

.END

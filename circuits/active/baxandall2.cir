Baxandall active EQ circuit for tonestack

* Insert you circuit in the area marked below - do not change anything else.
* The input to your circuit is node 2 relative to node 0 which is ground
* The output of your circuit must be node 3

* Four potentiometers are nominally available for you to use in your circuit:
* Pot 1 must consist of RP1LO and RP1HI
* Pot 2 must consist of RP2LO and RP2HI
* Pot 3 must consist of RP3LO and RP3HI
* Pot 4 must consist of RP4LO and RP4HI - this is cuurently inactive

* Nodes 0 to 9 are reserved

VIN 0 1 DC 0 AC 1
R98 1 2 47

******* PLACE YOUR CIRCUIT HERE *******
.INCLUDE OPAMP1.cir

XOPAMP1 0 50 3 OPAMP1

RP1LO 12 11 50K
RP1HI 11 10 50K

R1 2  10 22K
R2 50 11 22K
R3 12 3  22K
C1 10 12 47N

RP3LO 32 31 50K
RP3HI 31 30 50K

R4 2  30 10K
R5 32 3  10K
C2 50 31 470P

******* PLACE YOUR CIRCUIT HERE *******

R99 3 0 10K

.OPTIONS NOACCT
.AC DEC 40 10 100K

.END

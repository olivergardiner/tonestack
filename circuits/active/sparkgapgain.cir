Template circuit for tonestack

* Insert you circuit in the area marked below - do not change anything else.
* The input to your circuit is node 2 relative to node 0 which is ground
* The output of your circuit must be node 3

* Four potentiometers are available for you to use in your circuit
* Each pot mus consist of two resistors: RPxLO and RPxHI
* RPxLO and RPxHI must be connected in series
* RPxHI is zero when the pot is fully CCW

* Nodes 0 to 9 are reserved

VIN 0 1 DC 0 AC 1
R98 1 2 100

******* PLACE YOUR CIRCUIT HERE *******
.INCLUDE OPAMP1.cir

XOPAMP1 2 10 3 OPAMP1

RP1LO 3  10 5K
RP1HI 10 11 5K

R1 10 11 2.2K
R2 11 12 100

C1 3  10 2.2N
C2 12 0  10U

******* PLACE YOUR CIRCUIT HERE *******

R99 3 0 100K

.OPTIONS NOACCT
.AC DEC 40 10 100K

.END
